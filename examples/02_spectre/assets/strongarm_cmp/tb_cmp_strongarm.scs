// StrongArm Dynamic Comparator — SAR ADC Testbench
// Process  : TSMC 28nm HPC+ (CRN28HPC+ULL)
// VDD      : 0.9 V   Vcm : 0.45 V (= VDD/2)   Vid : 1 mV
// CLK rate : 1 GHz   Preset: conservative
// Design targets:  Tcmp < 50 ps,  Input-referred noise < 400 µV rms
//
// StrongArm topology (4-phase operation)
// ─────────────────────────────────────────────────────────────────
//  RESET  (CLK=0) : PMOS reset pull VP1/VN1/LP/LM → VDD
//                   M79 (source=LM, drain=LP) equalises latch nodes
//  INTEGRATION    : CLK rises, tail M88 turns on; M0/M1 discharge
//                   VN1 faster if VINP>VINN (more Vgs → more Id)
//  REGENERATION   : NMOS latch M45/M6 + PMOS latch M48/M49 kick in;
//                   LP/LM race to VDD/0 with time-constant τ = C/gm
//  OUTPUT BUFFER  : Double inverter per rail: LP → net1 → DCMPP
//                                             LM → net2 → DCMPN
//
// Transistor mapping:
//   VS              tail node (source of M0 & M1)
//   VP1             drain of M1 (VINN input transistor)
//   VN1             drain of M0 (VINP input transistor)
//   LP, LM          differential latch nodes (observable at top level)
//   DCMPP, DCMPN    buffered digital outputs
//   net1 = inv(LM)  intermediate buffer node
//   net2 = inv(LP)  intermediate buffer node
// ─────────────────────────────────────────────────────────────────
simulator lang=spectre
global 0
parameters VDD=0.9 Vcm=0.45 Vid=1m f=1G
include "/home/process/tsmc28n/PDK_mmWave/iPDK_CRN28HPC+ULL_v1.8_2p2a_20190531/tsmcN28/../models/spectre/toplevel.scs" section=TOP_TT

// ── Subcircuit ─────────────────────────────────────────────────────────────
// Identical transistors to tb_cmp_pss_pnoise.scs (original Virtuoso export)
// No layout-parameter changes; proven-good in Spectre.
subckt CMP_BUFF CLK DCMPN DCMPP LM LP VDD VINN VINP VSS
    M88 (VS CLK VSS VSS) nch_ulvt_mac l=30n w=2u multi=1 nf=4 sd=100n \
        ad=1e-13 as=1.5e-13 pd=2.4u ps=3.6u nrd=0.229097 nrs=0.229097 \
        sa=344.542n sb=344.542n sa1=294.801n sa2=336.962n sa3=409.667n \
        sa4=342.239n sb1=294.801n sb2=336.962n sb3=409.667n spa=100n \
        spa1=100n spa2=100n spa3=100n sap=151.977n sapb=166.788n \
        spba=115.715n spba1=117.043n dfm_flag=0 spmt=1.11111e+15 spomt=0 \
        spomt1=1.11111e+60 spmb=1.11111e+15 spomb=0 spomb1=1.11111e+60
    M10 (net1 LM VSS VSS) nch_ulvt_mac l=30n w=500n multi=1 nf=1 sd=100n \
        ad=5e-14 as=5e-14 pd=1.2u ps=1.2u nrd=0.572742 nrs=0.572742 \
        sa=205.00n sb=205.00n sa1=205.00n sa2=205.00n sa3=205.00n \
        sa4=205.00n sb1=205.00n sb2=205.00n sb3=205.00n spa=100n spa1=100n \
        spa2=100n spa3=100n sap=128.203n sapb=146.81n spba=115.715n \
        spba1=117.043n dfm_flag=0 spmt=1.11111e+15 spomt=0 \
        spomt1=1.11111e+60 spmb=1.11111e+15 spomb=0 spomb1=1.11111e+60
    M16 (net2 LP VSS VSS) nch_ulvt_mac l=30n w=500n multi=1 nf=1 sd=100n \
        ad=5e-14 as=5e-14 pd=1.2u ps=1.2u nrd=0.572742 nrs=0.572742 \
        sa=205.00n sb=205.00n sa1=205.00n sa2=205.00n sa3=205.00n \
        sa4=205.00n sb1=205.00n sb2=205.00n sb3=205.00n spa=100n spa1=100n \
        spa2=100n spa3=100n sap=128.203n sapb=146.81n spba=115.715n \
        spba1=117.043n dfm_flag=0 spmt=1.11111e+15 spomt=0 \
        spomt1=1.11111e+60 spmb=1.11111e+15 spomb=0 spomb1=1.11111e+60
    M1 (VP1 VINN VS VSS) nch_ulvt_mac l=30n w=16.0u multi=1 nf=32 sd=100n \
        ad=8e-13 as=9.55e-13 pd=19.2u ps=20.82u nrd=0.034712 nrs=0.034712 \
        sa=1.24563u sb=1.24563u sa1=581.909n sa2=955.685n sa3=1.05624u \
        sa4=1.22761u sb1=581.909n sb2=955.685n sb3=1.05624u spa=100n \
        spa1=100n spa2=100n spa3=100n sap=232.461n sapb=229.4n \
        spba=115.715n spba1=117.043n dfm_flag=0 spmt=1.11111e+15 spomt=0 \
        spomt1=1.11111e+60 spmb=1.11111e+15 spomb=0 spomb1=1.11111e+60
    M0 (VN1 VINP VS VSS) nch_ulvt_mac l=30n w=16.0u multi=1 nf=32 sd=100n \
        ad=8e-13 as=8.5e-13 pd=19.2u ps=20.4u nrd=0.034712 nrs=0.034712 \
        sa=1.24563u sb=1.24563u sa1=581.909n sa2=955.685n sa3=1.05624u \
        sa4=1.22761u sb1=581.909n sb2=955.685n sb3=1.05624u spa=100n \
        spa1=100n spa2=100n spa3=100n sap=232.461n sapb=229.4n \
        spba=115.715n spba1=117.043n dfm_flag=0 spmt=1.11111e+15 spomt=0 \
        spomt1=1.11111e+60 spmb=1.11111e+15 spomb=0 spomb1=1.11111e+60
    M45 (LM LP VN1 VSS) nch_ulvt_mac l=30n w=4u multi=1 nf=8 sd=100n \
        ad=2e-13 as=2.5e-13 pd=4.8u ps=6u nrd=0.127276 nrs=0.127276 \
        sa=500.763n sb=500.763n sa1=367.435n sa2=469.653n sa3=589.129n \
        sa4=495.622n sb1=367.435n sb2=469.653n sb3=589.129n spa=100n \
        spa1=100n spa2=100n spa3=100n sap=171.886n sapb=182.92n \
        spba=115.715n spba1=117.043n dfm_flag=0 spmt=1.11111e+15 spomt=0 \
        spomt1=1.11111e+60 spmb=1.11111e+15 spomb=0 spomb1=1.11111e+60
    M6 (LP LM VP1 VSS) nch_ulvt_mac l=30n w=4u multi=1 nf=8 sd=100n \
        ad=2e-13 as=2.5e-13 pd=4.8u ps=6u nrd=0.127276 nrs=0.127276 \
        sa=500.763n sb=500.763n sa1=367.435n sa2=469.653n sa3=589.129n \
        sa4=495.622n sb1=367.435n sb2=469.653n sb3=589.129n spa=100n \
        spa1=100n spa2=100n spa3=100n sap=171.886n sapb=182.92n \
        spba=115.715n spba1=117.043n dfm_flag=0 spmt=1.11111e+15 spomt=0 \
        spomt1=1.11111e+60 spmb=1.11111e+15 spomb=0 spomb1=1.11111e+60
    M105 (DCMPN net2 VSS VSS) nch_ulvt_mac l=30n w=1.5u multi=1 nf=3 \
        sd=100n ad=1e-13 as=1e-13 pd=2.4u ps=2.4u nrd=0.286371 \
        nrs=0.286371 sa=301.258n sb=301.258n sa1=270.414n sa2=297.334n \
        sa3=348.872n sa4=299.72n sb1=270.414n sb2=297.334n sb3=348.872n \
        spa=100n spa1=100n spa2=100n spa3=100n sap=145.425n sapb=161.365n \
        spba=115.715n spba1=117.043n dfm_flag=0 spmt=1.11111e+15 spomt=0 \
        spomt1=1.11111e+60 spmb=1.11111e+15 spomb=0 spomb1=1.11111e+60
    M106 (DCMPP net1 VSS VSS) nch_ulvt_mac l=30n w=1.5u multi=1 nf=3 \
        sd=100n ad=1e-13 as=1e-13 pd=2.4u ps=2.4u nrd=0.286371 \
        nrs=0.286371 sa=301.258n sb=301.258n sa1=270.414n sa2=297.334n \
        sa3=348.872n sa4=299.72n sb1=270.414n sb2=297.334n sb3=348.872n \
        spa=100n spa1=100n spa2=100n spa3=100n sap=145.425n sapb=161.365n \
        spba=115.715n spba1=117.043n dfm_flag=0 spmt=1.11111e+15 spomt=0 \
        spomt1=1.11111e+60 spmb=1.11111e+15 spomb=0 spomb1=1.11111e+60
    M2 (VSS VN1 VSS VSS) nch_ehvt_mac l=1u w=500n multi=1 nf=1 sd=120.0n \
        ad=4.75e-14 as=4.75e-14 pd=1.19u ps=1.19u nrd=0.645705 \
        nrs=0.645705 sa=95.0n sb=95.0n sa1=95.0n sa2=95.0n sa3=95.0n \
        sa4=95.0n sb1=95.0n sb2=95.0n sb3=95.0n spa=120.0n spa1=120.0n \
        spa2=120.0n spa3=120.0n sap=112.128n sapb=128.193n spba=175.499n \
        spba1=229.783n dfm_flag=0 spmt=1.11111e+15 spomt=0 \
        spomt1=1.11111e+60 spmb=1.11111e+15 spomb=0 spomb1=1.11111e+60
    M23 (VSS VP1 VSS VSS) nch_ehvt_mac l=1u w=500n multi=1 nf=1 sd=120.0n \
        ad=4.75e-14 as=4.75e-14 pd=1.19u ps=1.19u nrd=0.645705 \
        nrs=0.645705 sa=95.0n sb=95.0n sa1=95.0n sa2=95.0n sa3=95.0n \
        sa4=95.0n sb1=95.0n sb2=95.0n sb3=95.0n spa=120.0n spa1=120.0n \
        spa2=120.0n spa3=120.0n sap=112.128n sapb=128.193n spba=175.499n \
        spba1=229.783n dfm_flag=0 spmt=1.11111e+15 spomt=0 \
        spomt1=1.11111e+60 spmb=1.11111e+15 spomb=0 spomb1=1.11111e+60
    M78 (DCMPP net1 VDD VDD) pch_ulvt_mac l=30n w=1.5u multi=1 nf=3 \
        sd=100n ad=1e-13 as=1e-13 pd=2.4u ps=2.4u nrd=0.112412 \
        nrs=0.112412 sa=301.258n sb=301.258n sa1=270.414n sa2=297.334n \
        sa3=348.872n sa4=299.72n sb1=270.414n sb2=297.334n sb3=348.872n \
        spa=100n spa1=100n spa2=100n spa3=100n sap=145.425n sapb=161.365n \
        spba=115.715n spba1=117.043n dfm_flag=0 spmt=1.11111e+15 spomt=0 \
        spomt1=1.11111e+60 spmb=1.11111e+15 spomb=0 spomb1=1.11111e+60
    M77 (DCMPN net2 VDD VDD) pch_ulvt_mac l=30n w=1.5u multi=1 nf=3 \
        sd=100n ad=1e-13 as=1e-13 pd=2.4u ps=2.4u nrd=0.112412 \
        nrs=0.112412 sa=301.258n sb=301.258n sa1=270.414n sa2=297.334n \
        sa3=348.872n sa4=299.72n sb1=270.414n sb2=297.334n sb3=348.872n \
        spa=100n spa1=100n spa2=100n spa3=100n sap=145.425n sapb=161.365n \
        spba=115.715n spba1=117.043n dfm_flag=0 spmt=1.11111e+15 spomt=0 \
        spomt1=1.11111e+60 spmb=1.11111e+15 spomb=0 spomb1=1.11111e+60
    M79 (LP CLK LM VDD) pch_ulvt_mac l=30n w=500n multi=1 nf=1 sd=100n \
        ad=5e-14 as=5e-14 pd=1.2u ps=1.2u nrd=0.224825 nrs=0.224825 \
        sa=205.00n sb=205.00n sa1=205.00n sa2=205.00n sa3=205.00n \
        sa4=205.00n sb1=205.00n sb2=205.00n sb3=205.00n spa=100n spa1=100n \
        spa2=100n spa3=100n sap=128.203n sapb=146.81n spba=115.715n \
        spba1=117.043n dfm_flag=0 spmt=1.11111e+15 spomt=0 \
        spomt1=1.11111e+60 spmb=1.11111e+15 spomb=0 spomb1=1.11111e+60
    M5 (VP1 CLK VDD VDD) pch_ulvt_mac l=30n w=2u multi=1 nf=4 sd=100n \
        ad=1e-13 as=1.5e-13 pd=2.4u ps=3.6u nrd=0.089930 nrs=0.089930 \
        sa=344.542n sb=344.542n sa1=294.801n sa2=336.962n sa3=409.667n \
        sa4=342.239n sb1=294.801n sb2=336.962n sb3=409.667n spa=100n \
        spa1=100n spa2=100n spa3=100n sap=151.977n sapb=166.788n \
        spba=115.715n spba1=117.043n dfm_flag=0 spmt=1.11111e+15 spomt=0 \
        spomt1=1.11111e+60 spmb=1.11111e+15 spomb=0 spomb1=1.11111e+60
    M4 (VN1 CLK VDD VDD) pch_ulvt_mac l=30n w=2u multi=1 nf=4 sd=100n \
        ad=1e-13 as=1.5e-13 pd=2.4u ps=3.6u nrd=0.089930 nrs=0.089930 \
        sa=344.542n sb=344.542n sa1=294.801n sa2=336.962n sa3=409.667n \
        sa4=342.239n sb1=294.801n sb2=336.962n sb3=409.667n spa=100n \
        spa1=100n spa2=100n spa3=100n sap=151.977n sapb=166.788n \
        spba=115.715n spba1=117.043n dfm_flag=0 spmt=1.11111e+15 spomt=0 \
        spomt1=1.11111e+60 spmb=1.11111e+15 spomb=0 spomb1=1.11111e+60
    M7 (LP CLK VDD VDD) pch_ulvt_mac l=30n w=2u multi=1 nf=4 sd=100n \
        ad=1e-13 as=1.5e-13 pd=2.4u ps=3.6u nrd=0.089930 nrs=0.089930 \
        sa=344.542n sb=344.542n sa1=294.801n sa2=336.962n sa3=409.667n \
        sa4=342.239n sb1=294.801n sb2=336.962n sb3=409.667n spa=100n \
        spa1=100n spa2=100n spa3=100n sap=151.977n sapb=166.788n \
        spba=115.715n spba1=117.043n dfm_flag=0 spmt=1.11111e+15 spomt=0 \
        spomt1=1.11111e+60 spmb=1.11111e+15 spomb=0 spomb1=1.11111e+60
    M50 (LM CLK VDD VDD) pch_ulvt_mac l=30n w=2u multi=1 nf=4 sd=100n \
        ad=1e-13 as=1.5e-13 pd=2.4u ps=3.6u nrd=0.089930 nrs=0.089930 \
        sa=344.542n sb=344.542n sa1=294.801n sa2=336.962n sa3=409.667n \
        sa4=342.239n sb1=294.801n sb2=336.962n sb3=409.667n spa=100n \
        spa1=100n spa2=100n spa3=100n sap=151.977n sapb=166.788n \
        spba=115.715n spba1=117.043n dfm_flag=0 spmt=1.11111e+15 spomt=0 \
        spomt1=1.11111e+60 spmb=1.11111e+15 spomb=0 spomb1=1.11111e+60
    M48 (LM LP VDD VDD) pch_ulvt_mac l=30n w=4u multi=1 nf=8 sd=100n \
        ad=2e-13 as=2.5e-13 pd=4.8u ps=6u nrd=0.049961 nrs=0.049961 \
        sa=500.763n sb=500.763n sa1=367.435n sa2=469.653n sa3=589.129n \
        sa4=495.622n sb1=367.435n sb2=469.653n sb3=589.129n spa=100n \
        spa1=100n spa2=100n spa3=100n sap=171.886n sapb=182.92n \
        spba=115.715n spba1=117.043n dfm_flag=0 spmt=1.11111e+15 spomt=0 \
        spomt1=1.11111e+60 spmb=1.11111e+15 spomb=0 spomb1=1.11111e+60
    M49 (LP LM VDD VDD) pch_ulvt_mac l=30n w=4u multi=1 nf=8 sd=100n \
        ad=2e-13 as=2.5e-13 pd=4.8u ps=6u nrd=0.049961 nrs=0.049961 \
        sa=500.763n sb=500.763n sa1=367.435n sa2=469.653n sa3=589.129n \
        sa4=495.622n sb1=367.435n sb2=469.653n sb3=589.129n spa=100n \
        spa1=100n spa2=100n spa3=100n sap=171.886n sapb=182.92n \
        spba=115.715n spba1=117.043n dfm_flag=0 spmt=1.11111e+15 spomt=0 \
        spomt1=1.11111e+60 spmb=1.11111e+15 spomb=0 spomb1=1.11111e+60
    M19 (net1 LM VDD VDD) pch_ulvt_mac l=30n w=500n multi=1 nf=1 sd=100n \
        ad=5e-14 as=5e-14 pd=1.2u ps=1.2u nrd=0.224825 nrs=0.224825 \
        sa=205.00n sb=205.00n sa1=205.00n sa2=205.00n sa3=205.00n \
        sa4=205.00n sb1=205.00n sb2=205.00n sb3=205.00n spa=100n spa1=100n \
        spa2=100n spa3=100n sap=128.203n sapb=146.81n spba=115.715n \
        spba1=117.043n dfm_flag=0 spmt=1.11111e+15 spomt=0 \
        spomt1=1.11111e+60 spmb=1.11111e+15 spomb=0 spomb1=1.11111e+60
    M21 (net2 LP VDD VDD) pch_ulvt_mac l=30n w=500n multi=1 nf=1 sd=100n \
        ad=5e-14 as=5e-14 pd=1.2u ps=1.2u nrd=0.224825 nrs=0.224825 \
        sa=205.00n sb=205.00n sa1=205.00n sa2=205.00n sa3=205.00n \
        sa4=205.00n sb1=205.00n sb2=205.00n sb3=205.00n spa=100n spa1=100n \
        spa2=100n spa3=100n sap=128.203n sapb=146.81n spba=115.715n \
        spba1=117.043n dfm_flag=0 spmt=1.11111e+15 spomt=0 \
        spomt1=1.11111e+60 spmb=1.11111e+15 spomb=0 spomb1=1.11111e+60
ends CMP_BUFF

// ── Testbench ──────────────────────────────────────────────────────────────
// Differential input: VINP = Vcm + Vid/2,  VINN = Vcm - Vid/2
// For Vid=1mV: VINP=0.4505 V, VINN=0.4495 V  → VINP > VINN (positive input)
V3 (VINN 0) vsource dc=Vcm-0.5*Vid type=dc
V2 (VINP 0) vsource dc=Vcm+0.5*Vid type=dc
V1 (VSS 0)  vsource dc=0 type=dc
V0 (VDD 0)  vsource dc=VDD type=dc
V4 (CLK 0)  vsource type=pulse val0=0 val1=VDD period=1/f rise=10p fall=10p \
    delay=0 width=0.5/f

// DUT: StrongArm comparator (CMP_BUFF subcircuit)
I4 (CLK DCMPN DCMPP LM LP VDD VINN VINP VSS) CMP_BUFF

// ── Simulation options ─────────────────────────────────────────────────────
simulatorOptions options psfversion="1.4.0" temp=27 tnom=27 scalem=1.0 \
    scale=1.0 gmin=1e-12 rforce=1 maxnotes=5 maxwarns=5 digits=5 cols=80 \
    pivrel=1e-3 sensfile="../psf/sens.output" checklimitdest=psf

// PSS: 1 clock period (1 ns), 10 harmonics
pss  pss  fund=1G  harms=10  errpreset=conservative  autotstab=yes \
    saveinit=yes  annotate=status

// Pnoise: sampled noise, jitter event on latch nodes LP/LM
// Outputs input-referred noise spectral density: out [V/√Hz] vs freq
pnoise pnoise start=0 stop=500M pnoisemethod=fullspectrum \
    noisetype=sampled measurement=[pm0] annotate=status
pm0 jitterevent trigger=[I4.LP I4.LM] triggerthresh=50m triggernum=1 \
    triggerdir=rise target=[I4.LP I4.LM]

// ── Info output ────────────────────────────────────────────────────────────
modelParameter info what=models where=rawfile
element info what=inst where=rawfile
outputParameter info what=output where=rawfile
designParamVals info what=parameters where=rawfile
primitives info what=primitives where=rawfile
subckts info what=subckts where=rawfile

// Save: top-level nodes + internal VX nodes for 4-phase waveform analysis
save CLK VINP VINN DCMPN DCMPP LP LM V0:p I4.VP1 I4.VN1 I4.VS
saveOptions options save=selected
